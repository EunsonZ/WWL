CG LNA Rs=100 ideal LEVEL1 no PDK
.temp 27
.options reltol=1e-7 abstol=1e-14 vntol=1e-9
Vsig sig 0 DC .1 AC 1
RS sig s 100
VDD vdd 0 1.8
VG g 0 0.79920947376656803
RD vdd d 800
M1 d g s s NN W=10u L=1u
Cgs g s .5p
Cgd g d .05p
Cds d s .1p
Cout d out 1n
RL out 0 1k noisy=0
.model NN NMOS LEVEL=1 KP=.02 VTO=.5 LAMBDA=.02 GAMMA=0 TOX=20n TNOM=27
.control
set noaskquit
set numdgt=15
set filetype=ascii
op
print v(d) v(g) v(s) @m1[id] @m1[gm] @m1[gds] @m1[vdsat]
print @m1[cgs] @m1[cgd] @m1[cgb]
write op.raw all
set wr_vecnames
set wr_singlescale
ac lin 1 1000000 1000000
wrdata ac-1000000.txt v(out) v(s) v(d)
noise v(out) Vsig lin 1 1000000 1000000 1
write noise-1000000.raw all
print all
ac lin 1 90000000 90000000
wrdata ac-90000000.txt v(out) v(s) v(d)
noise v(out) Vsig lin 1 90000000 90000000 1
write noise-90000000.raw all
print all
ac lin 1 100000000 100000000
wrdata ac-100000000.txt v(out) v(s) v(d)
noise v(out) Vsig lin 1 100000000 100000000 1
write noise-100000000.raw all
print all
ac lin 1 110000000 110000000
wrdata ac-110000000.txt v(out) v(s) v(d)
noise v(out) Vsig lin 1 110000000 110000000 1
write noise-110000000.raw all
print all
quit
.endc
.end
